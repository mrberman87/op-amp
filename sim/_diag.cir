v4 DC diagnosis
.include v4.inc
.param C3v=4p
RINM INM 0 1u
VSRC INP 0 DC 0
RL   OUT 0 10k
.control
op
print v(n_q1g) v(n_q2g) v(n_q1s) v(n_q2s) v(n_q1d) v(n_x) v(n_mc) v(n_vb) v(n_mire) v(n_y) v(n_q5c) v(n_q5e) v(n_b1) v(n_q12b) v(n_b2) v(out)
.endc
.end
