v4c Cdom=47p
.include v4c.inc
.param Cdv=47p
RINM INM 0 1u
VSRC INP 0 DC 0 AC 1
RL   OUT 0 10k
.control
op
ac dec 24 10 1gig
print v(out)
.endc
.end
