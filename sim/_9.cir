Rz small sweep Cc1=4p Rz=47
.include v8.inc
.param R7v=1.5k Rzv=47 Cc1v=4p
RINM INM 0 1u
VSRC INP 0 DC 0 AC 1
RL   OUT 0 10k
.control
op
ac dec 30 10 1gig
print v(out)
.endc
.end
