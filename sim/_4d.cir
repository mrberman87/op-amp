v4d R7=1.5k R8=150 C4=470p Cdom=9p
.include v4d.inc
.param R7v=1.5k R8v=150 C4v=470p Cdv=9p
RINM INM 0 1u
VSRC INP 0 DC 0 AC 1
RL   OUT 0 10k
.control
op
ac dec 24 10 1gig
print v(out)
.endc
.end
