v1 DC sweep in ON state (X=9.5)
.include v1l.inc
RINM INM 0 1u
VSRC INP 0 DC 0
RL   OUT 0 10k
.control
dc VSRC -20u 20u 1u
wrdata v1l_s2.dat v(inp) v(n_q2g) v(n_x) v(n_q5c) v(out)
echo done
.endc
.end
