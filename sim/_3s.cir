v3 servo-AC C3=22p
.include v3s.inc
.param C3v=22p
VSRC INP 0 DC 0 AC 1
RL   OUT 0 10k
.control
op
print v(out) v(n_x) v(n_q5c) vcc#branch
ac dec 24 10 1gig
print v(out)
.endc
.end
