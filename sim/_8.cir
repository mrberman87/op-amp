v8 R7=330
.include v8.inc
.param R7v=330
RINM INM 0 1u
VSRC INP 0 DC 0 AC 1
RL   OUT 0 10k
.control
op
ac dec 30 10 1gig
print v(out)
.endc
.end
