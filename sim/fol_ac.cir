v1 follower AC as-schematic
.include v1fc.inc
.param C3v=220p
RINM INM OUT 0.01
VSRC INP 0 DC 1 AC 1
RL   OUT 0 10k
.nodeset v(n_q1d)=10 v(n_x)=9.5 v(n_y)=8.9 v(n_q5c)=6 v(n_b1)=-0.6 v(n_b2)=-1.2 v(out)=0.9
.control
op
ac dec 20 10 200meg
print v(out)
.endc
.end
