v1 DC check
.include v1l.inc
RINM INM OUT 0.01
VSRC INP 0 DC 0
RL   OUT 0 10k
.control
op
set width=120
print v(inp) v(inm) v(out) v(n_q1g) v(n_q2g) v(n_q1s) v(n_q2s) v(n_tail) v(n_q1d) v(n_x) v(n_y) v(n_q5c) v(n_b1) v(n_b2) vcc#branch
print @j1[id] @j2[id] @j1[vds] @j2[vds] @j1[vgs] @j2[vgs] @j1[gm] @j2[gm] @q3[ic]
.endc
.end
