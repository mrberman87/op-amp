v1 lead-comp C3=33p Rser=200
.include var2.inc
.param C3v=33p Rmx=200
RINM INM 0 1u
VSRC INP 0 DC 0 AC 1
RL   OUT 0 10k
.nodeset v(n_q1d)=10 v(n_x)=9.5 v(n_y)=8.9 v(n_q5c)=6 v(n_b1)=-0.6 v(n_b2)=-1.2 v(out)=0.9
.control
op
ac dec 16 10 200meg
print v(out)
.endc
.end
