Cg dominant at VAS collector Cg=220p
.include v8.inc
.param R7v=1.5k Rzv=0 Cc1v=0.1p
Cg n_q5c 0 220p
RINM INM 0 1u
VSRC INP 0 DC 0 AC 1
RL   OUT 0 10k
.control
op
ac dec 30 10 1gig
print v(out)
.endc
.end
