R9=6.8k
.include vfull.inc
.param R9v=6.8k
RINM INM 0 1u
VSRC INP 0 DC 0
RL   OUT 0 10k
.control
op
print v(out) v(n_q5c) v(n_b1) v(n_b2)
.endc
.end
