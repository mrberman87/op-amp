follower AC (centered)
.include vfull.inc
.param Cc1v=6.8p Cz=22p R6v=950
RINM INM OUT 0.01
VSRC INP 0 DC 0 AC 1
RL   OUT 0 10k
.control
op
print v(out)
ac dec 50 10 200meg
print v(out)
.endc
.end
