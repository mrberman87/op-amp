v2 open-loop AC
.include v2p.inc
.param R16v=22k
.param RBXv=100k
.param R6v=4.7k
.param RY2v=100k
RLEAK1 n_q1g 0 100M
RLEAK2 n_q2g 0 100M
RINM INM 0 1u
VSRC INP 0 DC 0 AC 1
RL   OUT 0 10k
.control
op
ac dec 10 10 10meg
let gain=db(v(out))
let ph=phase(v(out))
wrdata v2_ac.dat gain ph v(out)
echo AC done
.endc
.end
