v3 fast-parts C3=22p
.include v3.inc
.param C3v=22p
RINM INM 0 1u
VSRC INP 0 DC 0 AC 1
RL   OUT 0 10k
.control
op
print v(out) v(n_x) v(n_y) v(n_q5c) vcc#branch
ac dec 20 10 1gig
print v(out)
.endc
.end
