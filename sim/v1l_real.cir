v1 correct gate leaks (100 Meg)
.include v1l.inc
RINM INM 0 1u
VSRC INP 0 DC 0
RL   OUT 0 10k
.control
dc VSRC -20u 20u 10u
print v(inp) v(n_q2g) v(n_q1g) v(n_q2s) v(n_x) v(n_q1d) v(n_y) v(n_q5c) v(out) i(vsrc)
.endc
.end
