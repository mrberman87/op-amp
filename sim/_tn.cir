trim+nodeset t=0.570
.include vbest.inc
.param t=0.570
RINM INM 0 1u
VSRC INP 0 DC 0
RL   OUT 0 10k
.nodeset v(n_q1d)=10 v(n_x)=5.2 v(n_q1s)=0.93 v(n_q2s)=0.93 v(n_mc)=9.7 v(n_vb)=9.0 v(n_y)=4.6 v(n_q5c)=-2.8 v(n_b1)=-3.5 v(n_b2)=-5 v(out)=-4.3
.control
op
print v(out) v(n_x) v(n_q5c)
.endc
.end
