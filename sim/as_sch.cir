v1 AS-SCHEMATIC verification (C3=220p, R19/RY=100k, RLEAK 100Meg)
.include v1fc.inc
.param C3v=220p
RINM INM 0 1u
VSRC INP 0 DC 0 AC 1
RL   OUT 0 10k
.control
op
print v(out) v(n_x) v(n_y) v(n_q5c) v(n_b1) v(n_b2) v(q1s) i(vcc)
set filetype=ascii
wrdata as_sch_ol.dat v(out)
ac dec 16 10 200meg
wrdata as_sch_ac.dat v(out)
.endc
.end
