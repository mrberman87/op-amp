v1 diagonal
.include v1l.inc
RINM INM 0 1u
VSRC INP 0 DC 0 AC 1
RL   OUT 0 10k
.control
op
set width=120
print @j1[id] @j2[id] @j1[vgs] @j2[vgs] @j1[gm] @j2[gm] @q3[ic]
ac dec 5 10 100k
set width=120
print v(inp) v(n_q2g) v(n_q1g) v(n_q2s) v(n_q1s) v(n_tail) v(n_q1d) v(n_x)
.endc
.end
