v1 original topology, closed-loop, probe internal AC
.include v1l.inc
RINM INM OUT 0.01
VSRC INP 0 DC 0 AC 1
RL   OUT 0 10k
.control
op
print v(n_x) v(n_y) v(n_q5c) v(n_b1) v(n_b2) v(n_q1d) v(n_mire) v(n_q1s) v(n_q2s) v(n_tail)
ac dec 10 10 10meg
wrdata v1l_probe.dat v(inp) v(n_q1g) v(n_q2g) v(n_x) v(n_y) v(n_q5c) v(n_b1) v(out)
.endc
.end
