v5 nested-miller C3=6p Cc2=150p
.include v5.inc
.param C3v=6p Cc2v=150p
RINM INM 0 1u
VSRC INP 0 DC 0 AC 1
RL   OUT 0 10k
.control
op
ac dec 24 10 1gig
print v(out)
.endc
.end
