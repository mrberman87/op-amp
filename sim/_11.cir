R6 AC-bypassed Cc1=15p
.include v8.inc
.param R7v=1.5k Rzv=0 Cc1v=15p
C6 n_q5e VCC 100n
RINM INM 0 1u
VSRC INP 0 DC 0 AC 1
RL   OUT 0 10k
.control
op
ac dec 30 10 1gig
print v(out)
.endc
.end
