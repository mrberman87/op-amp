AC trace through intermediate nodes
.include core.inc
.include bench_ol.inc
.control
ac dec 25 10 100meg
wrdata ac_trace.dat v(inp) v(n_q2g) v(n_q1g) v(n_x) v(n_y) v(n_q5c) v(n_b1) v(out)
echo done
.endc
.end
